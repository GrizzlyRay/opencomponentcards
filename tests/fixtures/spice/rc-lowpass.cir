* Synthetic RC low-pass. Invented test fixture, not a measurement of a real part.
* The -3 dB point is where the magnitude of V(out) is 1/sqrt(2), or -3.0103 dB.
* WHEN v(out)=0.5 finds that point only for this circuit. A .meas card reads
* v(out) as the real part, and on a unity-gain low-pass the real part is 0.5
* at the same frequency where the magnitude is 1/sqrt(2). Any other gain or
* transfer function puts those two frequencies in different places.
* ngspice-47 cannot parse vdb() or vm() on a .meas card. The meas command
* below is the same request, and it does accept vdb().
V1 in 0 DC 0 AC 1
R1 in out {p_r1_resistance}
C1 out 0 {p_c1_capacitance}
* Other bound card parameters, not in the signal path:
* {p_r1_tcr}
* {p_c1_dc_bias_factor}
* {p_c1_temperature_factor}
* {p_c1_aging_per_decade_hour}
.control
ac dec 100 0.1 100
meas ac f3db WHEN vdb(out)=-3.0103
.endc
.end
